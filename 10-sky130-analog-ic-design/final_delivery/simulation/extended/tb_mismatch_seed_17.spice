* SKY130 v8 mismatch point sample, seed 17.
.lib "/home/nehan/.volare/volare/sky130/versions/0fe599b2afb6708d281543108caf8310912f54af/sky130A/libs.tech/combined/sky130.lib.spice" tt_mm
.option seed=17
.include ../final/opamp_rri_final.spice
Vdd vdd 0 1.8
Ibn vdd ibn 20u
Ibp ibp 0 20u
Ibp2 ibp2 0 20u
Vcm inp 0 dc 0.65
Vfb out inn 0
CL out 0 2p
Xamp inp inn out vdd 0 ibn ibp ibp2 opamp_rri_final
.control
op
let Voffset = v(out)-v(inp)
print Voffset
let Idd = -i(Vdd)
print Idd
.endc
.end
