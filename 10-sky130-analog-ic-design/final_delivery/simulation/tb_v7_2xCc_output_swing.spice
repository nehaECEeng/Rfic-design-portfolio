* Unity-follower output-swing exploration with 2 pF load.
.lib "/home/nehan/.volare/volare/sky130/versions/0fe599b2afb6708d281543108caf8310912f54af/sky130A/libs.tech/combined/sky130.lib.spice" tt
.include ../candidates/rri_tail_headroom_v7_2xCc.spice
Vdd vdd 0 1.8
Ibn vdd ibn 20u
Ibp ibp 0 20u
Ibp2 ibp2 0 20u
Vcm inp 0 dc 0.10
Vfb out inn 0
CL out 0 2p
Xamp inp inn out vdd 0 ibn ibp ibp2 opamp_rri_final
.control
dc Vcm 0.10 1.70 0.025
print v(inp) v(out) v(inn)
wrdata ../results/v7_2xCc_output_swing.dat v(out)
.endc
.end
